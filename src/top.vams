`timescale 1ns/1ps
//////////////////////////////////////////////////////////////////////////////////
// Company:
// Engineer: Chanaka Ashan Ganewattha
//
// Create Date: 12/27/2017:30:52 AM
// Design Name: DSM_WITH_ECG
// Module Name: top
// Project Name: Development of an Analog Front End for Bio Signal Processing
// Tool Versions: Questa-ADMS
// Description:
//
// Dependencies:
//
// Revision:
// Revision 0.01 - File Created
// Additional Comments:
//
//////////////////////////////////////////////////////////////////////////////////
`include "disciplines.vams"

module top;
	electrical aclk;
	electrical gnd;
	ground gnd;

	wire dclk,clk;

	//clock #(.period(1000)) clock_gen(.clk(dclk));
	//resistor #(.res(10k)) r1(.p(dclk),.n(gnd));
	//resistor #(.res(10k)) r2(.p(q), .n(gnd));
	pulse #(.period(1000)) pulse_source(.out(pulse_out));

	clockCheck testClock(.out(dclk), .in(pulse_out));

endmodule
