//////////////////////////////////////////////////////////////////////////////////
// Company:
// Engineer: Chanaka Ashan Ganewattha
//
// Create Date: 12/27/2017:30:52 AM
// Design Name: DSM_WITH_ECG
// Module Name: pulse generator
// Project Name: Development of an Analog Front End for Bio Signal Processing
// Tool Versions: Questa-ADMS
// Description:
//
// Dependencies:
//
// Revision:
// Revision 0.01 - File Created
// Additional Comments:
//
//////////////////////////////////////////////////////////////////////////////////
`timescale 1ns/1ps
`include "disciplines.vams"

module pulse(out);
	parameter real period = 100;
	parameter real vdd = 5.0;
	parameter real tr = 1n;
	parameter real tf = 1n;

	output out;
	electrical out;
	reg clk;

	real vout = 0.0;

	initial begin
		clk = 1'b0;
	end

	always #(period/2) clk = ~clk;

	always @(clk) begin
		case(clk)
			1'b1 : vout = vdd;
			1'b0 : vout = 0.0;
		endcase
	end

	analog begin
		V(out) <+ transition(vout,0,tr,tf);
	end
endmodule
