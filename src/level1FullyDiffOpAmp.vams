//////////////////////////////////////////////////////////////////////////////////
// Company:
// Engineer: Chanaka Ashan Ganewattha
//
// Create Date: 12/27/2017:30:52 AM
// Design Name: DSM_WITH_ECG
// Module Name: level1FullyDiffOpAmp
// Project Name: Development of an Analog Front End for Bio Signal Processing
// Tool Versions: Questa-ADMS
// Description:
//
// Dependencies:
//
// Revision:
// Revision 0.01 - File Created
// Additional Comments:
//
//////////////////////////////////////////////////////////////////////////////////
`include "disciplines.vams"
`include "constants.vams"
`include "vcvs.vams"
`include "resistor.vams"

module level1FullyDiffOpAmp(op,on,ip,in,gnd);
	parameter real f_u = 50M;	//unity gain frequency
	parameter real A = 100k;	//voltage gain
	parameter real res = 1k;	//resistor for pole
	parameter real f_pole = f_u/A;	//pole at f_u/A
	parameter real cap = 1/(2 * `M_PI * res * f_pole);	//calculate cap value for pole resistor
	parameter real r_out = 100;		//output resistance

	input ip,in;
	inout gnd;
	output op,on;

	electrical ip,in,out,gnd;

	electrical pv,pc,ovp,ovn;

	vcvs #(.gain(A)) vegain(.op(pv),.on(gnd),.ip(ip),.in(in));
	resistor #(.res(res)) rp1(.p(pc),.n(pv));
	capacitor #(.cap(cap)) cp1(.p(pc),.n(gnd));

	vcvs #(.gain(0.5)) vebufferp(.op(ovp),.on(gnd),.ip(pc),.in(gnd));
	resistor #(.res(r_out)) routp(.p(op),.n(ovp));

	vcvs #(.gain(0.5)) vebuffern(.op(gnd),.on(ovn),.ip(pc),.in(gnd));
	resistor #(.res(r_out)) routn(.p(on),.n(ovn));
endmodule
