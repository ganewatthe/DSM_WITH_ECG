`timescale 1ns/1ps
`include "disciplines.vams"

connectmodule d2a(out,in);
	parameter real v0 = 0.0;
	parameter real v1 = 5.0;
	parameter real vx = 2.5;
	parameter real vz = 5.0;
	parameter real r0 = 1k from (0:inf);
	parameter real r1 = 1k from (0:inf);
	parameter real rx = 100 from (0:inf);
	parameter real rz = 1M from (0:inf);
	parameter real tr = 1n from [0:inf);
	parameter real tf = 1n from [0:inf);

	input in;
	output out;
	logic in;
	electrical out;
	real v, r;

	initial begin
		case(in)
			1'b0 : begin
				v = v0;
				r = r0;
			end
			1'b1 : begin
				v = v1;
				r = r1;
			end
			1'bx : begin
				v = vx;
				r = rx;
			end
			1'bz : begin
				v = vz;
				r = rz;
			end
		endcase
	end

	always @(in) begin
		case(in)
			1'b0 : begin
				v = v0;
				r = r0;
			end
			1'b1 : begin
				v = v1;
				r = r1;
			end
			1'bx : begin
				v = vx;
				r = rx;
			end
			1'bz : begin
				v = vz;
				r = rz;
			end
		endcase
	end

	analog begin
		V(out) <+ transition(v, 0, tr, tf) + transition(r, 0, tr, tf) * I(out);
	end

endmodule
